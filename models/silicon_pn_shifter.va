// ============================================================================
// Circuit-Ready Compact Model: Silicon PN Carrier-Depletion Phase Shifter
// Auto-generated from Cross-Platform Physics-Informed Surrogate Framework
// Compatible with Cadence Spectre / Ansys Lumerical INTERCONNECT
// ============================================================================
`include "constants.vams"
`include "disciplines.vams"

module silicon_pn_phase_shifter(anode, cathode, phi_out, loss_db_out);
    inout anode, cathode;
    output phi_out, loss_db_out;
    electrical anode, cathode, phi_out, loss_db_out;

    parameter real length_mm      = 4.0   from (0.5:10.0);
    parameter real c_j0_pf_mm     = 0.25  from (0.05:2.0);
    parameter real r_series_ohm   = 25.0  from (1.0:500.0);
    parameter real alpha0_db_cm   = 12.0  from (1.0:50.0);
    parameter real wavelength_um  = 1.55;

    localparam real ALPHA_MOD = 8.53011127e-05;
    localparam real V_BI      = 0.778040;
    localparam real P_EXP     = 0.500000;

    real v_rev, c_j, delta_neff, delta_phi_rad, total_loss_db;

    analog begin
        v_rev = max(0.0, V(cathode, anode));
        c_j = (c_j0_pf_mm * 1.0e-12 * length_mm) / pow(1.0 + v_rev / V_BI, P_EXP);
        I(cathode, anode) <+ ddt(c_j * V(cathode, anode));

        delta_neff = ALPHA_MOD * (pow(V_BI + v_rev, P_EXP) - pow(V_BI, P_EXP));
        delta_phi_rad = (2.0 * `M_PI * (length_mm * 1000.0) * delta_neff) / wavelength_um;
        total_loss_db = (alpha0_db_cm - 0.35 * v_rev) * (length_mm * 0.1);

        V(phi_out)     <+ delta_phi_rad;
        V(loss_db_out) <+ total_loss_db;
    end
endmodule
